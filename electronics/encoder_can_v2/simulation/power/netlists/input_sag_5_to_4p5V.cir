Encoder CAN power: input_sag_5_to_4p5V
* TI SBVM961 port: S2 Ron/Roff and Von/Voff swapped to avoid ngspice reverse-R clamp bug.
* ngspice clamps new Ron to 1mohm; documented in model_port.md. V_out selects 3.3V.
.param V_out=3.3
.include "/Users/sovest/Project/vptc-calc/electronics/encoder_can_v2/simulation/power/vendor/tps7a20-adj_trans_ngspice.lib"
.options reltol=0.001 abstol=1e-9 vntol=1e-6 itl4=200 method=gear
Vsource vsrc 0 PWL(0 0 0.001 0 0.00101 5 0.005 5 0.00501 4.5 0.008 4.5 0.00801 5 0.012 5)
Rsource vsrc source_l 0.2
Lsource source_l vin 1e-06
XU5 vin 0 vin nc vout TPS7A20_ADJ_TRANS
* NC is unused model pin, matching DBV pin4.
Rnc nc 0 1e12
Rcin vin cin_esr .02
C10 cin_esr 0 1.3e-06
* C11 is local LDO output cap; remaining 3V3 caps combined behind estimated trace impedance.
Rcout vout cout_esr .01323
C11 cout_esr 0 1.65e-06
Rplane vout remote_l 0.05
Lplane remote_l remote 5e-09
Rremote remote remote_cap .01323
Cremote remote_cap 0 2.765e-06
Vcommand loadcmd 0 PWL(0 0.15 0.012 0.15)
* V2 sensitivity: all equivalent load is placed at the remote rail, after distribution R/L.
* Load current scales with the remote rail below 3.3V; no current is drawn at 0V.
Bload remote 0 I={v(loadcmd)*min(max(v(remote)/3.3,0),1)}
Rleak vout 0 1e9
.save v(vsrc) v(vin) v(vout) v(remote) v(loadcmd) i(vsource)
.tran 0.2u .012 0 0.2u
.end
